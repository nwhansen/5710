// Generated for: spectre
// Generated on: Oct 30 11:05:34 2014
// Design library name: Lib6710_08
// Design cell name: Allparts
// Design view name: schematic
simulator lang=spectre
global 0 vdd!
include "/uusoc/facility/cad_common/local/class/6710/F13/cadence/Spectre/T89Y.scs"

// Library name: Lib6710_08
// Cell name: TIEHI
// View name: analog_extracted
subckt TIEHI Y
    \+1 (Y 4 vdd! vdd!) ami06P w=3e-06 l=6e-07 as=4.5e-12 ad=4.5e-12 \
        ps=6e-06 pd=6e-06 m=1 region=sat
    \+5 (0 4) capacitor c=6.5286e-16 m=1
    \+4 (vdd! 4) capacitor c=4.4361e-16 m=1
    \+3 (0 4) capacitor c=2.7636e-16 m=1
    \+2 (vdd! Y) capacitor c=9.2064e-16 m=1
    \+0 (4 4 0 0) ami06N w=1.5e-06 l=6e-07 as=2.25e-12 ad=2.25e-12 \
        ps=4.5e-06 pd=4.5e-06 m=1 region=sat
ends TIEHI
// End of subcircuit definition.

// Library name: Lib6710_08
// Cell name: NOR2X1
// View name: analog_extracted
subckt NOR2X1 A B Y
    \+3 (Y B 6 vdd!) ami06P w=3e-06 l=6e-07 as=1.35e-12 ad=4.5e-12 \
        ps=9e-07 pd=6e-06 m=1 region=sat
    \+2 (6 A vdd! vdd!) ami06P w=3e-06 l=6e-07 as=4.5e-12 ad=1.35e-12 \
        ps=6e-06 pd=9e-07 m=1 region=sat
    \+10 (B 0) capacitor c=7.2819e-16 m=1
    \+9 (A 0) capacitor c=5.6079e-16 m=1
    \+8 (vdd! B) capacitor c=5.9427e-16 m=1
    \+7 (vdd! A) capacitor c=7.1145e-16 m=1
    \+6 (Y 0) capacitor c=1.95594e-15 m=1
    \+5 (B Y) capacitor c=4.149e-16 m=1
    \+4 (vdd! Y) capacitor c=2.03172e-15 m=1
    \+1 (0 B Y 0) ami06N w=1.5e-06 l=6e-07 as=1.35e-12 ad=2.25e-12 \
        ps=1.8e-06 pd=4.5e-06 m=1 region=sat
    \+0 (Y A 0 0) ami06N w=1.5e-06 l=6e-07 as=2.25e-12 ad=1.35e-12 \
        ps=4.5e-06 pd=1.8e-06 m=1 region=sat
ends NOR2X1
// End of subcircuit definition.

// Library name: Lib6710_08
// Cell name: TIELO
// View name: analog_extracted
subckt TIELO Y
    \+1 (4 4 vdd! vdd!) ami06P w=3e-06 l=6e-07 as=4.5e-12 ad=4.5e-12 \
        ps=6e-06 pd=6e-06 m=1 region=sat
    \+5 (0 4) capacitor c=5.6079e-16 m=1
    \+4 (vdd! 4) capacitor c=6.7797e-16 m=1
    \+3 (Y 0) capacitor c=4.7694e-16 m=1
    \+2 (vdd! 4) capacitor c=2.4678e-16 m=1
    \+0 (Y 4 0 0) ami06N w=1.5e-06 l=6e-07 as=2.25e-12 ad=2.25e-12 \
        ps=4.5e-06 pd=4.5e-06 m=1 region=sat
ends TIELO
// End of subcircuit definition.

// Library name: Lib6710_08
// Cell name: NAND2X1
// View name: analog_extracted
subckt NAND2X1 A B Y
    \+3 (vdd! B Y vdd!) ami06P w=3e-06 l=6e-07 as=2.7e-12 ad=4.5e-12 \
        ps=1.8e-06 pd=6e-06 m=1 region=sat
    \+2 (Y A vdd! vdd!) ami06P w=3e-06 l=6e-07 as=4.5e-12 ad=2.7e-12 \
        ps=6e-06 pd=1.8e-06 m=1 region=sat
    \+10 (B 0) capacitor c=6.9471e-16 m=1
    \+9 (A 0) capacitor c=4.7709e-16 m=1
    \+8 (vdd! B) capacitor c=5.4405e-16 m=1
    \+7 (vdd! A) capacitor c=7.1145e-16 m=1
    \+6 (Y 0) capacitor c=1.79508e-15 m=1
    \+5 (B Y) capacitor c=4.149e-16 m=1
    \+4 (vdd! Y) capacitor c=1.89678e-15 m=1
    \+1 (Y B 6 0) ami06N w=3e-06 l=6e-07 as=1.35e-12 ad=4.5e-12 ps=9e-07 \
        pd=6e-06 m=1 region=sat
    \+0 (6 A 0 0) ami06N w=3e-06 l=6e-07 as=4.5e-12 ad=1.35e-12 ps=6e-06 \
        pd=9e-07 m=1 region=sat
ends NAND2X1
// End of subcircuit definition.

// Library name: Lib6710_08
// Cell name: Allparts
// View name: schematic
I7 (net1) TIEHI
I6 (net3 net4 net2) NOR2X1
I8 (net5) TIELO
I5 (net7 net8 net6) NAND2X1
simulatorOptions options reltol=1e-3 vabstol=1e-6 iabstol=1e-12 temp=27 \
    tnom=27 scalem=1.0 scale=1.0 gmin=1e-12 rforce=1 maxnotes=5 maxwarns=5 \
    digits=5 cols=80 pivrel=1e-3 sensfile="../psf/sens.output" \
    checklimitdest=psf
modelParameter info what=models where=rawfile
element info what=inst where=rawfile
outputParameter info what=output where=rawfile
designParamVals info what=parameters where=rawfile
primitives info what=primitives where=rawfile
subckts info what=subckts  where=rawfile
saveOptions options save=allpub
