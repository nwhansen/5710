// Design: ExperimentalCells/XOR_TEST
simulator lang=spectre
global 0 vdd!
include "/uusoc/facility/cad_common/local/class/6710/F13/cadence/Spectre/T89Y.scs"

// Lib6710_08/XOR2X1/schematic
subckt XOR2X1 A B Y inh_inh_bn
    M11 (net8 A 0 gnd!) ami06N w=1.5u l=600n m=1 region=sat
    M10 (net7 B 0 gnd!) ami06N w=1.5u l=600n m=1 region=sat
    M3 (net20 B 0 gnd!) ami06N w=1.5u l=600n m=1 region=sat
    M2 (net19 net7 0 gnd!) ami06N w=1.5u l=600n m=1 region=sat
    M1 (Y A net20 gnd!) ami06N w=1.5u l=600n m=1 region=sat
    M0 (Y net8 net19 gnd!) ami06N w=1.5u l=600n m=1 region=sat
    M9 (net7 B vdd! vdd!) ami06P w=3u l=600n m=1 region=sat
    M8 (net8 A vdd! vdd!) ami06P w=3u l=600n m=1 region=sat
    M7 (net21 A vdd! vdd!) ami06P w=3u l=600n m=1 region=sat
    M6 (net21 B vdd! vdd!) ami06P w=3u l=600n m=1 region=sat
    M5 (Y net7 net21 vdd!) ami06P w=3u l=600n m=1 region=sat
    M4 (Y net8 net21 vdd!) ami06P w=3u l=600n m=1 region=sat
ends XOR2X1

// ExperimentalCells/XOR_TEST/schematic
C0 (Y 0) capacitor c=100.0f m=1
V1 (B 0) vsource type=pulse val0=0 val1=5 period=80n width=40n
V0 (A 0) vsource type=pulse val0=0 val1=5 period=40n width=20n
V2 (vdd! 0) vsource type=dc dc=5
I6 (A B Y 0) XOR2X1
simulatorOptions options temp=27
tran tran stop=80n
