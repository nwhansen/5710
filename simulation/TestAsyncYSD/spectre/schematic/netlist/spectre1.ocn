simulator( 'spectre )
design(	 "/home/nathan/5710/simulation/TestAsyncYSD/spectre/schematic/netlist/netlist")
resultsDir( "/home/nathan/5710/simulation/TestAsyncYSD/spectre/schematic" )
modelFile(
    '("/uusoc/facility/cad_common/local/class/6710/F13/cadence/Spectre/T89Y.scs" "")
)
analysis('tran ?stop "1.2u"  )
envOption(
	'analysisOrder  list("tran")
)
temp( 27 )
run()
selectResult( 'tran )
plot(getData("/CLK") getData("/CLR") getData("/D") getData("/Q") getData("/net5") )
