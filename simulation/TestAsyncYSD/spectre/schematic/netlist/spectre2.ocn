simulator( 'spectre )
design(	 "/home/nathan/5710/simulation/TestAsyncYSD/spectre/schematic/netlist/netlist")
resultsDir( "/home/nathan/5710/simulation/TestAsyncYSD/spectre/schematic" )
modelFile(
    '("/uusoc/facility/cad_common/local/class/6710/F13/cadence/Spectre/T89Y.scs" "")
)
analysis('tran ?stop "200n"  )
envOption(
	'analysisOrder  list("tran")
)
temp( 27 )
run()
selectResult( 'tran )
plot(getData("/net6") getData("/net4") getData("/net3") getData("/net2") )
modelFile(
    '("/uusoc/facility/cad_common/local/class/6710/F13/cadence/Spectre/T89Y.scs" "")
)
run()
selectResult( 'tran )
plot(getData("/net2") getData("/net3") getData("/net4") getData("/net6") )
modelFile(
    '("/uusoc/facility/cad_common/local/class/6710/F13/cadence/Spectre/T89Y.scs" "")
)
save( 'i "/V2/MINUS" "/V2/PLUS" )
run()
selectResult( 'tran )
plot(getData("/net2") getData("/net3") getData("/net4") getData("/net6") getData("/V2/MINUS") getData("/V2/PLUS") )
modelFile(
    '("/uusoc/facility/cad_common/local/class/6710/F13/cadence/Spectre/T89Y.scs" "")
)
save( 'i /V2/MINUS /V2/PLUS )
run()
selectResult( 'tran )
plot(getData("/net2") getData("/net3") getData("/net4") getData("/net6") )
