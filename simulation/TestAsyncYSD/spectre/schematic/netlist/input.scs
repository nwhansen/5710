// Design: ExperimentalCells/TestAsyncYSD
simulator lang=spectre
global 0 vdd!
include "/uusoc/facility/cad_common/local/class/6710/F13/cadence/Spectre/T89Y.scs"

// ExperimentalCells/YSDFlipFlopAsyncReset/schematic
subckt YSDFlipFlopAsyncReset CLK CLR D Q QBar inh_inh_bn _net0
    M15 (net014 CLR vdd! _net0) ami06P w=3u l=600n m=1 region=sat
    M5 (QBar Q vdd! _net0) ami06P w=3u l=600n m=1 region=sat
    M4 (Q net16 vdd! _net0) ami06P w=3u l=600n m=1 region=sat
    M3 (net16 net14 vdd! _net0) ami06P w=3u l=600n m=1 region=sat
    M2 (net14 CLK vdd! _net0) ami06P w=3u l=600n m=1 region=sat
    M1 (net10 CLK net31 _net0) ami06P w=6u l=600n m=1 region=sat
    M0 (net31 D vdd! _net0) ami06P w=6u l=600n m=1 region=sat
    M18 (net014 CLR 0 inh_inh_bn) ami06N w=1.5u l=600n m=1 region=sat
    M21 (net14 net014 0 inh_inh_bn) ami06N w=3u l=600n m=1 region=sat
    M12 (QBar Q 0 inh_inh_bn) ami06N w=1.5u l=600n m=1 region=sat
    M11 (Q net16 0 inh_inh_bn) ami06N w=1.5u l=600n m=1 region=sat
    M10 (net16 CLK net25 inh_inh_bn) ami06N w=3u l=600n m=1 region=sat
    M9 (net25 net14 0 inh_inh_bn) ami06N w=3u l=600n m=1 region=sat
    M8 (net14 net10 net27 inh_inh_bn) ami06N w=3u l=600n m=1 region=sat
    M7 (net27 CLK 0 inh_inh_bn) ami06N w=3u l=600n m=1 region=sat
    M6 (net10 D 0 inh_inh_bn) ami06N w=1.5u l=600n m=1 region=sat
ends YSDFlipFlopAsyncReset

// ExperimentalCells/TestAsyncYSD/schematic
V0 (vdd! 0) vsource type=dc dc=5
V3 (D 0) vsource type=pulse val0=0 val1=5 period=90n delay=5n width=45n
V2 (CLR 0) vsource type=pulse val0=5 val1=0 period=200n delay=5n width=100n
V1 (CLK 0) vsource type=pulse val0=0 val1=5 period=40n width=20n
C1 (Q 0) capacitor c=100f m=1
C0 (net5 0) capacitor c=100f m=1
I0 (CLK CLR D Q net5 0 vdd!) YSDFlipFlopAsyncReset
simulatorOptions options temp=27
tran tran stop=1.2u
