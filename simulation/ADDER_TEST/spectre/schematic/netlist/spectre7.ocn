simulator( 'spectre )
design(	 "/home/nathan/5710/simulation/ADDER_TEST/spectre/schematic/netlist/netlist")
resultsDir( "/home/nathan/5710/simulation/ADDER_TEST/spectre/schematic" )
modelFile(
    '("/uusoc/facility/cad_common/local/class/6710/F13/cadence/Spectre/T89Y.scs" "")
)
analysis('tran ?stop "160n"  )
envOption(
	'analysisOrder  list("tran")
)
temp( 27 )
run()
selectResult( 'tran )
plot(getData("/C") getData("/S") getData("/Cin") getData("/B") getData("/A") )
modelFile(
    '("/uusoc/facility/cad_common/local/class/6710/F13/cadence/Spectre/T89Y.scs" "")
)
run()
selectResult( 'tran )
plot(getData("/A") getData("/B") getData("/Cin") getData("/S") getData("/C") )
modelFile(
    '("/uusoc/facility/cad_common/local/class/6710/F13/cadence/Spectre/T89Y.scs" "")
)
run()
selectResult( 'tran )
plot(getData("/A") getData("/B") getData("/Cin") getData("/S") getData("/C") )
modelFile(
    '("/uusoc/facility/cad_common/local/class/6710/F13/cadence/Spectre/T89Y.scs" "")
)
run()
selectResult( 'tran )
plot(getData("/A") getData("/B") getData("/Cin") getData("/S") getData("/C") )
modelFile(
    '("/uusoc/facility/cad_common/local/class/6710/F13/cadence/Spectre/T89Y.scs" "")
)
run()
selectResult( 'tran )
plot(getData("/A") getData("/B") getData("/Cin") getData("/S") getData("/C") )
