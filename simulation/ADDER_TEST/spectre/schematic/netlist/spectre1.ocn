simulator( 'spectre )
design(	 "/home/nathan/5710/simulation/ADDER_TEST/spectre/schematic/netlist/netlist")
resultsDir( "/home/nathan/5710/simulation/ADDER_TEST/spectre/schematic" )
modelFile(
    '("/uusoc/facility/cad_common/local/class/6710/F13/cadence/Spectre/T89Y.scs" "")
)
analysis('tran ?stop "160n"  )
envOption(
	'analysisOrder  list("tran")
)
temp( 27 )
run()
selectResult( 'tran )
plot(getData("/net4") getData("/net5") getData("/net3") getData("/net2") getData("/net1") )
