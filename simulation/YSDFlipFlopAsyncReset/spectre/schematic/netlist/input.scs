// Design: TestCharacterize/YSDFlipFlopAsyncReset
simulator lang=spectre
global 0 vdd!
include "/uusoc/facility/cad_common/local/class/6710/F13/cadence/Spectre/T89Y.scs"

// TestCharacterize/YSDFlipFlopAsyncReset/schematic
M15 (net014 CLR vdd! vdd!) ami06P w=3u l=600n m=1 region=sat
M5 (QBar Q vdd! vdd!) ami06P w=3u l=600n m=1 region=sat
M4 (Q net16 vdd! vdd!) ami06P w=3u l=600n m=1 region=sat
M3 (net16 net14 vdd! vdd!) ami06P w=3u l=600n m=1 region=sat
M2 (net14 CLK vdd! vdd!) ami06P w=3u l=600n m=1 region=sat
M1 (net10 CLK net31 vdd!) ami06P w=6u l=600n m=1 region=sat
M0 (net31 D vdd! vdd!) ami06P w=6u l=600n m=1 region=sat
M18 (net014 CLR 0 0) ami06N w=1.5u l=600n m=1 region=sat
M21 (net14 net014 0 0) ami06N w=3u l=600n m=1 region=sat
M12 (QBar Q 0 0) ami06N w=1.5u l=600n m=1 region=sat
M11 (Q net16 0 0) ami06N w=1.5u l=600n m=1 region=sat
M10 (net16 CLK net25 0) ami06N w=3u l=600n m=1 region=sat
M9 (net25 net14 0 0) ami06N w=3u l=600n m=1 region=sat
M8 (net14 net10 net27 0) ami06N w=3u l=600n m=1 region=sat
M7 (net27 CLK 0 0) ami06N w=3u l=600n m=1 region=sat
M6 (net10 D 0 0) ami06N w=1.5u l=600n m=1 region=sat
simulatorOptions options temp=27
