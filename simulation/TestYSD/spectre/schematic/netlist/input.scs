// Design: ExperimentalCells/TestYSD
simulator lang=spectre
global 0 vdd!
include "/uusoc/facility/cad_common/local/class/6710/F13/cadence/Spectre/T89Y.scs"

// ExperimentalCells/YSDFlipFlop/schematic
subckt YSDFlipFlop CLK D Q QBar inh_inh_bn _net0
    M5 (QBar Q vdd! _net0) ami06P w=3u l=600n m=1 region=sat
    M4 (Q net16 vdd! _net0) ami06P w=3u l=600n m=1 region=sat
    M3 (net16 net14 vdd! _net0) ami06P w=3u l=600n m=1 region=sat
    M2 (net14 CLK vdd! _net0) ami06P w=3u l=600n m=1 region=sat
    M1 (net10 CLK net31 _net0) ami06P w=6u l=600n m=1 region=sat
    M0 (net31 D vdd! _net0) ami06P w=6u l=600n m=1 region=sat
    M12 (QBar Q 0 inh_inh_bn) ami06N w=1.5u l=600n m=1 region=sat
    M11 (Q net16 0 inh_inh_bn) ami06N w=1.5u l=600n m=1 region=sat
    M10 (net16 CLK net25 inh_inh_bn) ami06N w=3u l=600n m=1 region=sat
    M9 (net25 net14 0 inh_inh_bn) ami06N w=3u l=600n m=1 region=sat
    M8 (net14 net10 net27 inh_inh_bn) ami06N w=3u l=600n m=1 region=sat
    M7 (net27 CLK 0 inh_inh_bn) ami06N w=3u l=600n m=1 region=sat
    M6 (net10 D 0 inh_inh_bn) ami06N w=1.5u l=600n m=1 region=sat
ends YSDFlipFlop

// ExperimentalCells/TestYSD/schematic
I0 (net1 net2 net4 net3 0 vdd!) YSDFlipFlop
V0 (vdd! 0) vsource type=dc dc=5
V2 (net2 0) vsource type=pulse val0=0 val1=5 period=30n delay=10n rise=1n fall=1n width=20n
V1 (net1 0) vsource type=pulse val0=0 val1=5 period=40n rise=1n fall=1n width=20n
C1 (net4 0) capacitor c=100f m=1
C0 (net3 0) capacitor c=100f m=1
simulatorOptions options temp=27
tran tran stop=900n
