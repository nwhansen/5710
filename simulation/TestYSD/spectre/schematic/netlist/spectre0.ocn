simulator( 'spectre )
design(	 "/home/nathan/5710/simulation/TestYSD/spectre/schematic/netlist/netlist")
resultsDir( "/home/nathan/5710/simulation/TestYSD/spectre/schematic" )
modelFile(
    '("/uusoc/facility/cad_common/local/class/6710/F13/cadence/Spectre/T89Y.scs" "")
)
analysis('tran ?stop "900n"  )
envOption(
	'analysisOrder  list("tran")
)
temp( 27 )
run()
selectResult( 'tran )
plot(getData("/net4") getData("/net2") getData("/net1") )
modelFile(
    '("/uusoc/facility/cad_common/local/class/6710/F13/cadence/Spectre/T89Y.scs" "")
)
run()
selectResult( 'tran )
plot(getData("/net4") getData("/net2") getData("/net1") )
modelFile(
    '("/uusoc/facility/cad_common/local/class/6710/F13/cadence/Spectre/T89Y.scs" "")
)
run()
selectResult( 'tran )
plot(getData("/net1") getData("/net2") getData("/net4") )
