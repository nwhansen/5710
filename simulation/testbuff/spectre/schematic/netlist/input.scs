// Design: Lib6710_08/testbuff
simulator lang=spectre
global 0 vdd!
include "/uusoc/facility/cad_common/local/class/6710/F13/cadence/Spectre/T89Y.scs"

// Lib6710_08/INV1/schematic
subckt INV1 A Y inh_inh_bn _net0
    M0 (Y A vdd! _net0) ami06P w=3u l=600n m=1 region=sat
    M1 (Y A 0 inh_inh_bn) ami06N w=1.5u l=600n m=1 region=sat
ends INV1

// Lib6710_08/INVX4/schematic
subckt INVX4 A Y inh_inh_bn _net0
    M0 (Y A 0 _net0) ami06N w=6u l=600n m=1 region=sat
    M1 (Y A vdd! inh_inh_bn) ami06P w=12.0u l=600n m=1 region=sat
ends INVX4

// Lib6710_08/BUFX4/schematic
subckt BUFX4 A Y inh_inh_bn _net0
    I0 (A net5 _net0 inh_inh_bn) INV1
    I1 (net5 Y inh_inh_bn _net0) INVX4
ends BUFX4

// Lib6710_08/testbuff/schematic
I0 (net2 net3 vdd! 0) BUFX4
V0 (vdd! 0) vsource type=dc dc=5
V1 (net2 0) vsource type=pulse val0=0 val1=5 period=20n width=10n
C0 (net3 0) capacitor c=1p m=1
simulatorOptions options temp=27
tran tran stop=100n
