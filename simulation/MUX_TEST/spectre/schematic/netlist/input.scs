// Design: ExperimentalCells/MUX_TEST
simulator lang=spectre
global 0 vdd!
include "/uusoc/facility/cad_common/local/class/6710/F13/cadence/Spectre/T89Y.scs"

// Lib6710_08/MUX2X1/schematic
subckt MUX2X1 A B S Y inh_inh_bn
    P1 (A net11 Y vdd!) ami06P w=3u l=600n m=1 region=sat
    P0 (B S Y vdd!) ami06P w=3u l=600n m=1 region=sat
    N1 (Y net11 B 0) ami06N w=1.5u l=600n m=1 region=sat
    N0 (Y S A 0) ami06N w=1.5u l=600n m=1 region=sat
    M0 (net11 S 0 gnd!) ami06N w=1.5u l=600n m=1 region=sat
    M1 (net11 S vdd! vdd!) ami06P w=3u l=600n m=1 region=sat
ends MUX2X1

// ExperimentalCells/MUX_TEST/schematic
I0 (A B Sel Y 0) MUX2X1
V2 (A 0) vsource type=pulse val0=0 val1=5 period=40n width=20n
V1 (B 0) vsource type=pulse val0=0 val1=5 period=80n width=40n
V0 (Sel 0) vsource type=pulse val0=0 val1=5 period=160n width=80n
V3 (vdd! 0) vsource type=dc dc=5
C0 (Y 0) capacitor c=100.0f m=1
simulatorOptions options temp=27
tran tran stop=160n
