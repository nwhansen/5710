simulator( 'spectre )
design(	 "/home/nathan/5710/simulation/MUX_TEST/spectre/schematic/netlist/netlist")
resultsDir( "/home/nathan/5710/simulation/MUX_TEST/spectre/schematic" )
modelFile(
    '("/uusoc/facility/cad_common/local/class/6710/F13/cadence/Spectre/T89Y.scs" "")
)
analysis('tran ?stop "400n"  )
envOption(
	'analysisOrder  list("tran")
)
temp( 27 )
run()
selectResult( 'tran )
plot(getData("/net3") getData("/net5") getData("/net2") getData("/net1") )
modelFile(
    '("/uusoc/facility/cad_common/local/class/6710/F13/cadence/Spectre/T89Y.scs" "")
)
run()
selectResult( 'tran )
plot(getData("/net1") getData("/net2") getData("/net5") getData("/net3") )
