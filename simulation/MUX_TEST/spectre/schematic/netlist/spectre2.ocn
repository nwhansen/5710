simulator( 'spectre )
design(	 "/home/nathan/5710/simulation/MUX_TEST/spectre/schematic/netlist/netlist")
resultsDir( "/home/nathan/5710/simulation/MUX_TEST/spectre/schematic" )
modelFile(
    '("/uusoc/facility/cad_common/local/class/6710/F13/cadence/Spectre/T89Y.scs" "")
)
analysis('tran ?stop "160n"  )
envOption(
	'analysisOrder  list("tran")
)
temp( 27 )
run()
selectResult( 'tran )
plot(getData("/Y") getData("/Sel") getData("/B") getData("/A") )
modelFile(
    '("/uusoc/facility/cad_common/local/class/6710/F13/cadence/Spectre/T89Y.scs" "")
)
run()
selectResult( 'tran )
plot(getData("/A") getData("/B") getData("/Sel") getData("/Y") )
modelFile(
    '("/uusoc/facility/cad_common/local/class/6710/F13/cadence/Spectre/T89Y.scs" "")
)
run()
selectResult( 'tran )
plot(getData("/A") getData("/B") getData("/Sel") getData("/Y") )
